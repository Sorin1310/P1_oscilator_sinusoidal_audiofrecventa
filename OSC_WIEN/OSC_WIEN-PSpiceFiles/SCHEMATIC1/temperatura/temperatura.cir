** Profile: "SCHEMATIC1-temperatura"  [ d:\p2\osc_wien\osc_wien-PSpiceFiles\SCHEMATIC1\temperatura.sim ]

** Creating circuit file "temperatura.cir"
** WARNING: THIS AUTOMATICALLY GENERATED FILE MAY BE OVERWRITTEN BY SUBSEQUENT SIMULATIONS

*Libraries:
* Profile Libraries :
* Local Libraries :
.LIB "c:/users/hp-pc/desktop/lib_modelepspice_anexa_1/modele_a1_lib/bc846b.lib"
.LIB "c:/users/hp-pc/desktop/lib_modelepspice_anexa_1/modele_a1_lib/bc856b.lib"
* From [PSPICE NETLIST] section of C:\SPB_Data\cdssetup\OrCAD_PSpice\17.2.0\PSpice.ini file:
.lib "nomd.lib"

*Analysis directives:
.TRAN  0 100m 0
.TEMP 0 25 70
.OPTIONS ADVCONV
.PROBE64 V(alias(*)) I(alias(*)) W(alias(*)) D(alias(*)) NOISE(alias(*))
.INC "..\SCHEMATIC1.net"

.END
